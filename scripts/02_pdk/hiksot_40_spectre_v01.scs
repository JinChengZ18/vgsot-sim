simulator lang = spectre

library hiksot_40spectre_v01

//****************************************************************************************************
//*                                  HIKSTOR SOT-MRAM SPECTRE MODEL                                       *
//****************************************************************************************************
//*
//*    PROCESS :  40 nm
//*    MODEL   :  SOT-MRAM HSPICE MODEL
//*    VERSION :  V0.1
//*    DATE    :  February 27, 2025
//****************************************************************************************************
//* In the input netlist, use the below .lib statements to call the desired
//* models in the model file:
//*
//*             Lib name                        								Description
//*
//*        include "hiksot_40_spectre_v01.scs" section=sot_tt               nominal typical SOT models
//*        include "hiksot_40_spectre_v01.scs" section=sot_ttg              nominal typical SOT models (Global Variation)
//*        include "hiksot_40_spectre_v01.scs" section=sot_ttl              nominal typical SOT models (Local Variation)
//*        include "hiksot_40_spectre_v01.scs" section=sot_mc               mc SOT models (Global Variation)
//****************************************************************************************************

//****************************************************************************************************
//*  Remark: Please be noted below device names in PDK.
//*             model name
//*			  	sot_mtj_ckt
//****************************************************************************************************

//******************************************Section TT************************************************
section sot_tt

parameters mismatchflag_rp = 0
parameters sigma_mis_rsot = 1
parameters sigma_mis_rp = 1
parameters sigma_mis_tmr = 1
statistics {
    mismatch
	{
        vary sigma_mis_rsot dist = gauss std = 0.07
		vary sigma_mis_rp dist = gauss std = 0.07
		vary sigma_mis_tmr dist = gauss std = 0.04
    }
}
include "hiksot_40_spectre_sot_v01.scs" section=tt

endsection

section sot_ttg

parameters mismatchflag_rp = 1
parameters sigma_mis_rsot = 1
parameters sigma_mis_rp = 1
parameters sigma_mis_tmr = 1
statistics {
    mismatch
	{
        vary sigma_mis_rsot dist = gauss std = 0.07
		vary sigma_mis_rp dist = gauss std = 0.07
		vary sigma_mis_tmr dist = gauss std = 0.04
    }
}
include "hiksot_40_spectre_sot_v01.scs" section=tt

endsection

section sot_ttl

parameters mismatchflag_rp = 1
parameters sigma_mis_rsot = 1
parameters sigma_mis_rp = 1
parameters sigma_mis_tmr = 1
statistics {
    mismatch
	{
        vary sigma_mis_rsot dist = gauss std = 0.07
		vary sigma_mis_rp dist = gauss std = 0.04
		vary sigma_mis_tmr dist = gauss std = 0.02
    }
}
include "hiksot_40_spectre_sot_v01.scs" section=tt

endsection

//******************************************Section MC************************************************
section sot_mc
ahdl_include "./sotmodel.va"

subckt sot_mtj_ckt(p q n)

parameters Rsot0 = 800
parameters Iop0 = 800u
parameters Rp0 = 11k
parameters TMR0 = 1.2
parameters Hx = 20
parameters IniState = 1

parameters Rsot_mis = 1
parameters Rp_mis = 1
parameters TMR_mis = 1

statistics {
    process {
        vary Rsot_mis dist = gauss std = 0.07
		vary Rp_mis dist = gauss std = 0.07
		vary TMR_mis dist = gauss std = 0.04
    }
}

X1 (p q n) sotmodel Rsot0=Rsot0 Iop0=Iop0 Rp0=Rp0 TMR0=TMR0 Hx=Hx IniState=IniState Rsot_mis=Rsot_mis Rp_mis=Rp_mis TMR_mis=TMR_mis

ends sot_mtj_ckt
endsection
